* C:\Users\Theje\eSim-Workspace\DCPS\DCPS.cir

* EESchema Netlist Version 1.1 (Spice format) creation date: 05/25/26 23:21:52

* To exclude a component from the Spice Netlist add [Spice_Netlist_Enabled] user FIELD set to: N
* To reorder the component spice node sequence add [Spice_Node_Sequence] user FIELD and define sequence: 2,1,0

* Sheet Name: /
v1  clkin GND pulse
v2  rst GND pulse
v3  Net-_U2-Pad3_ GND DC
U2  clkin rst Net-_U2-Pad3_ Net-_U2-Pad4_ GND Net-_U1-Pad1_ Net-_U1-Pad2_ Net-_U1-Pad3_ Net-_U1-Pad4_ Net-_U1-Pad5_ adc_bridge_5
U3  Net-_U1-Pad6_ Net-_U1-Pad7_ Net-_U1-Pad8_ Net-_U1-Pad9_ Net-_U1-Pad10_ clk00 clk90 clk180 clk270 clkout dac_bridge_5
v4  Net-_U2-Pad4_ GND DC
U4  clk00 plot_v1
U5  clk90 plot_v1
U6  clk180 plot_v1
U7  clk270 plot_v1
U8  clkout plot_v1
U1  Net-_U1-Pad1_ Net-_U1-Pad2_ Net-_U1-Pad3_ Net-_U1-Pad4_ Net-_U1-Pad5_ Net-_U1-Pad6_ Net-_U1-Pad7_ Net-_U1-Pad8_ Net-_U1-Pad9_ Net-_U1-Pad10_ clock_phase_shifter
U9  clkin plot_v1
U10  rst plot_v1

.end
