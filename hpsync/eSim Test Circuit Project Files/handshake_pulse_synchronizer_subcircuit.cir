* C:\FOSSEE\eSim\library\SubcircuitLibrary\handshake_pulse_synchronizer_subcircuit\handshake_pulse_synchronizer_subcircuit.cir

* EESchema Netlist Version 1.1 (Spice format) creation date: 04/11/26 00:22:13

* To exclude a component from the Spice Netlist add [Spice_Netlist_Enabled] user FIELD set to: N
* To reorder the component spice node sequence add [Spice_Node_Sequence] user FIELD and define sequence: 2,1,0

* Sheet Name: /
U1  Net-_U1-Pad1_ Net-_U1-Pad2_ Net-_U1-Pad3_ Net-_U1-Pad4_ Net-_U1-Pad5_ Net-_U1-Pad6_ handshake_pulse_sync_verilog
U3  Net-_U2-Pad1_ Net-_U2-Pad2_ Net-_U2-Pad3_ Net-_U2-Pad4_ Net-_U2-Pad5_ Net-_U1-Pad1_ Net-_U1-Pad2_ Net-_U1-Pad3_ Net-_U1-Pad4_ Net-_U1-Pad5_ adc_bridge_5
U4  Net-_U1-Pad6_ Net-_U2-Pad6_ dac_bridge_1
U2  Net-_U2-Pad1_ Net-_U2-Pad2_ Net-_U2-Pad3_ Net-_U2-Pad4_ Net-_U2-Pad5_ Net-_U2-Pad6_ PORT

.end
