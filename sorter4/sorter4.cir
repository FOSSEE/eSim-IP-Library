.title KiCad schematic
v4 Net-_U1-Pad4_ GND DC
v3 Net-_U1-Pad3_ GND DC
v1 Net-_U1-Pad1_ GND DC
v2 Net-_U1-Pad2_ GND DC
v7 Net-_U1-Pad7_ GND DC
v5 Net-_U1-Pad5_ GND DC
v6 Net-_U1-Pad6_ GND DC
v8 Net-_U1-Pad8_ GND DC
v14 Net-_U2-Pad6_ GND DC
v15 Net-_U2-Pad7_ GND DC
v11 Net-_U2-Pad3_ GND DC
v9 Net-_U2-Pad1_ GND DC
v13 Net-_U2-Pad5_ GND DC
v10 Net-_U2-Pad2_ GND DC
v12 Net-_U2-Pad4_ GND DC
v16 Net-_U2-Pad8_ GND DC
U5 Net-_U3-Pad25_ Net-_U3-Pad26_ Net-_U3-Pad27_ Net-_U3-Pad28_ Net-_U3-Pad29_ Net-_U3-Pad30_ Net-_U3-Pad31_ Net-_U3-Pad32_ y230 y220 y210 y200 y330 y320 y310 y300 dac_bridge_8
U3 Net-_U1-Pad9_ Net-_U1-Pad10_ Net-_U1-Pad11_ Net-_U1-Pad12_ Net-_U1-Pad13_ Net-_U1-Pad14_ Net-_U1-Pad15_ Net-_U1-Pad16_ Net-_U2-Pad9_ Net-_U2-Pad10_ Net-_U2-Pad11_ Net-_U2-Pad12_ Net-_U2-Pad13_ Net-_U2-Pad14_ Net-_U2-Pad15_ Net-_U2-Pad16_ Net-_U3-Pad17_ Net-_U3-Pad18_ Net-_U3-Pad19_ Net-_U3-Pad20_ Net-_U3-Pad21_ Net-_U3-Pad22_ Net-_U3-Pad23_ Net-_U3-Pad24_ Net-_U3-Pad25_ Net-_U3-Pad26_ Net-_U3-Pad27_ Net-_U3-Pad28_ Net-_U3-Pad29_ Net-_U3-Pad30_ Net-_U3-Pad31_ Net-_U3-Pad32_ bitonic_sort
U4 Net-_U3-Pad17_ Net-_U3-Pad18_ Net-_U3-Pad19_ Net-_U3-Pad20_ Net-_U3-Pad21_ Net-_U3-Pad22_ Net-_U3-Pad23_ Net-_U3-Pad24_ y030 y020 y010 y000 y130 y120 y110 y100 dac_bridge_8
U1 Net-_U1-Pad1_ Net-_U1-Pad2_ Net-_U1-Pad3_ Net-_U1-Pad4_ Net-_U1-Pad5_ Net-_U1-Pad6_ Net-_U1-Pad7_ Net-_U1-Pad8_ Net-_U1-Pad9_ Net-_U1-Pad10_ Net-_U1-Pad11_ Net-_U1-Pad12_ Net-_U1-Pad13_ Net-_U1-Pad14_ Net-_U1-Pad15_ Net-_U1-Pad16_ adc_bridge_8
U2 Net-_U2-Pad1_ Net-_U2-Pad2_ Net-_U2-Pad3_ Net-_U2-Pad4_ Net-_U2-Pad5_ Net-_U2-Pad6_ Net-_U2-Pad7_ Net-_U2-Pad8_ Net-_U2-Pad9_ Net-_U2-Pad10_ Net-_U2-Pad11_ Net-_U2-Pad12_ Net-_U2-Pad13_ Net-_U2-Pad14_ Net-_U2-Pad15_ Net-_U2-Pad16_ adc_bridge_8
U11 y120 plot_v1
U12 y110 plot_v1
U13 y100 plot_v1
U9 y000 plot_v1
U6 y030 plot_v1
U7 y020 plot_v1
U10 y130 plot_v1
U8 y010 plot_v1
U20 y310 plot_v1
U16 y210 plot_v1
U14 y230 plot_v1
U21 y300 plot_v1
U18 y330 plot_v1
U17 y200 plot_v1
U15 y220 plot_v1
U19 y320 plot_v1
.end
