* C:\Users\yamin\eSim-Workspace\round_robin\round_robin.cir

* EESchema Netlist Version 1.1 (Spice format) creation date: 03/29/26 11:22:10

* To exclude a component from the Spice Netlist add [Spice_Netlist_Enabled] user FIELD set to: N
* To reorder the component spice node sequence add [Spice_Node_Sequence] user FIELD and define sequence: 2,1,0

* Sheet Name: /
U9  clk reset req3 req2 req1 req0 Net-_U3-Pad1_ Net-_U3-Pad2_ Net-_U3-Pad3_ Net-_U3-Pad4_ Net-_U3-Pad5_ Net-_U3-Pad6_ adc_bridge_6
U10  Net-_U10-Pad1_ Net-_U10-Pad2_ Net-_U10-Pad3_ Net-_U10-Pad4_ grant3 grant2 grant1 grant0 dac_bridge_4
v1  clk GND pulse
v2  reset GND pulse
v3  req3 GND pulse
v4  req2 GND pulse
v5  req1 GND pulse
v6  req0 GND pulse
v7  VCC GND DC
U7  req0 plot_v1
U8  req0 plot_v1
U6  req1 plot_v1
U5  req2 plot_v1
U4  req3 plot_v1
U2  reset plot_v1
U1  clk plot_v1
U11  grant3 plot_v1
U12  grant2 plot_v1
U13  grant1 plot_v1
U14  grant0 plot_v1
U3  Net-_U3-Pad1_ Net-_U3-Pad2_ Net-_U3-Pad3_ Net-_U3-Pad4_ Net-_U3-Pad5_ Net-_U3-Pad6_ Net-_U10-Pad1_ Net-_U10-Pad2_ Net-_U10-Pad3_ Net-_U10-Pad4_ round_robin_arbiter_verilog

.end
