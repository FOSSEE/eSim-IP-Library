.title KiCad schematic
U2 Net-_U1-Pad5_ Net-_U1-Pad6_ Net-_U1-Pad7_ Net-_U1-Pad8_ Net-_U2-Pad5_ Net-_U2-Pad6_ Net-_U2-Pad7_ Net-_U2-Pad8_ Net-_U2-Pad9_ Net-_U2-Pad10_ Net-_U2-Pad11_ Net-_U2-Pad12_ Net-_U2-Pad13_ ps2_rx
U3 Net-_U2-Pad6_ Net-_U2-Pad7_ Net-_U2-Pad8_ Net-_U2-Pad9_ Net-_U2-Pad10_ Net-_U2-Pad11_ Net-_U2-Pad12_ Net-_U2-Pad13_ /rx_data7 /rx_data6 /rx_data5 /rx_data4 /rx_data3 /rx_data2 /rx_data1 /rx_data0 dac_bridge_8
U4 Net-_U2-Pad5_ /rx_done dac_bridge_1
U1 /clk /rst /ps2_clk /ps2_data Net-_U1-Pad5_ Net-_U1-Pad6_ Net-_U1-Pad7_ Net-_U1-Pad8_ adc_bridge_4
.end
