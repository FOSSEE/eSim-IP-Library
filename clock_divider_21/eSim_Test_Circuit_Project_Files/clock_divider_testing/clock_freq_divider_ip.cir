* C:\FOSSEE\eSim\library\SubcircuitLibrary\clock_freq_divider_ip\clock_freq_divider_ip.cir

* EESchema Netlist Version 1.1 (Spice format) creation date: 03/27/26 10:04:07

* To exclude a component from the Spice Netlist add [Spice_Netlist_Enabled] user FIELD set to: N
* To reorder the component spice node sequence add [Spice_Node_Sequence] user FIELD and define sequence: 2,1,0

* Sheet Name: /
U1  Net-_U1-Pad1_ Net-_U1-Pad2_ Net-_U1-Pad3_ clock_freq_divider_ip
U4  Net-_U1-Pad3_ Net-_U2-Pad5_ dac_bridge_1
U3  Net-_U2-Pad1_ Net-_U2-Pad2_ Net-_U1-Pad1_ Net-_U1-Pad2_ adc_bridge_2
U2  Net-_U2-Pad1_ Net-_U2-Pad2_ ? ? Net-_U2-Pad5_ PORT

.end
