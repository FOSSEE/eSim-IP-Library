* C:\FOSSEE\eSim\library\SubcircuitLibrary\two_ff_syncronizer_subcircuit\two_ff_syncronizer_subcircuit.cir

* EESchema Netlist Version 1.1 (Spice format) creation date: 05/18/26 23:04:16

* To exclude a component from the Spice Netlist add [Spice_Netlist_Enabled] user FIELD set to: N
* To reorder the component spice node sequence add [Spice_Node_Sequence] user FIELD and define sequence: 2,1,0

* Sheet Name: /
U1  Net-_U1-Pad1_ Net-_U1-Pad2_ Net-_U1-Pad3_ Net-_U1-Pad4_ two_ff_synchronizer
U3  Net-_U2-Pad1_ Net-_U2-Pad2_ Net-_U2-Pad3_ Net-_U1-Pad1_ Net-_U1-Pad2_ Net-_U1-Pad3_ adc_bridge_3
U4  Net-_U1-Pad4_ Net-_U2-Pad4_ dac_bridge_1
U2  Net-_U2-Pad1_ Net-_U2-Pad2_ Net-_U2-Pad3_ Net-_U2-Pad4_ PORT

.end
