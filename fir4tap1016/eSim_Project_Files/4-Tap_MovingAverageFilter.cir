* C:\FOSSEE\eSim-Workspace\4-Tap_MovingAverageFilter\4-Tap_MovingAverageFilter.cir

* EESchema Netlist Version 1.1 (Spice format) creation date: 03/14/26 14:21:00

* To exclude a component from the Spice Netlist add [Spice_Netlist_Enabled] user FIELD set to: N
* To reorder the component spice node sequence add [Spice_Node_Sequence] user FIELD and define sequence: 2,1,0

* Sheet Name: /
U1  Net-_U1-Pad1_ Net-_U1-Pad2_ Net-_U1-Pad3_ Net-_U1-Pad4_ Net-_U1-Pad5_ Net-_U1-Pad6_ Net-_U1-Pad7_ Net-_U1-Pad8_ Net-_U1-Pad9_ Net-_U1-Pad10_ Net-_U1-Pad11_ Net-_U1-Pad12_ Net-_U1-Pad13_ Net-_U1-Pad14_ Net-_U1-Pad15_ Net-_U1-Pad16_ Net-_U1-Pad17_ Net-_U1-Pad18_ moving_average_4tap
U2  Net-_U2-Pad1_ Net-_U1-Pad2_ adc_bridge_1
U5  GND GND GND Net-_U5-Pad4_ GND GND GND GND Net-_U1-Pad3_ Net-_U1-Pad4_ Net-_U1-Pad5_ Net-_U1-Pad6_ Net-_U1-Pad7_ Net-_U1-Pad8_ Net-_U1-Pad9_ Net-_U1-Pad10_ adc_bridge_8
U6  Net-_U1-Pad11_ Net-_U1-Pad12_ Net-_U1-Pad13_ Net-_U1-Pad14_ Net-_U1-Pad15_ Net-_U1-Pad16_ Net-_U1-Pad17_ Net-_U1-Pad18_ /OUT_1 /OUT_2 /OUT_3 /OUT_4 /OUT_5 /OUT_6 /OUT_7 /OUT_8 dac_bridge_8
v1  Net-_U2-Pad1_ GND pulse
v4  Net-_U5-Pad4_ GND pulse
U7  /OUT_1 plot_v1
U8  /OUT_2 plot_v1
U9  /OUT_8 plot_v1
v2  Net-_U3-Pad1_ GND pulse
U3  Net-_U3-Pad1_ Net-_U1-Pad1_ adc_bridge_1
U4  /OUT_3 plot_v1
U10  /OUT_4 plot_v1
U11  /OUT_5 plot_v1
U12  /OUT_6 plot_v1
U13  /OUT_7 plot_v1

.end
