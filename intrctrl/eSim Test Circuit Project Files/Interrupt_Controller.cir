* C:\Users\yamin\eSim-Workspace\Interrupt_Controller\Interrupt_Controller.cir

* EESchema Netlist Version 1.1 (Spice format) creation date: 03/24/26 17:18:09

* To exclude a component from the Spice Netlist add [Spice_Netlist_Enabled] user FIELD set to: N
* To reorder the component spice node sequence add [Spice_Node_Sequence] user FIELD and define sequence: 2,1,0

* Sheet Name: /
U9  Clk Net-_U8-Pad1_ adc_bridge_1
U10  rst Net-_U10-Pad2_ adc_bridge_1
U11  irq3 Net-_U11-Pad2_ adc_bridge_1
U12  irq2 Net-_U12-Pad2_ adc_bridge_1
U13  irq1 Net-_U13-Pad2_ adc_bridge_1
U14  irq0 Net-_U14-Pad2_ adc_bridge_1
U15  ack0 Net-_U15-Pad2_ adc_bridge_1
U16  Net-_U16-Pad1_ intr dac_bridge_1
U17  Net-_U17-Pad1_ int_id_0 dac_bridge_1
U7  Clk plot_v1
U6  rst plot_v1
U5  irq3 plot_v1
U4  irq2 plot_v1
U3  irq1 plot_v1
U2  irq0 plot_v1
U1  ack0 plot_v1
U19  intr plot_v1
U20  int_id_0 plot_v1
v8  VCC GND DC
v1  Clk GND pulse
v2  rst GND pulse
v3  irq3 GND pulse
v4  irq2 GND pulse
v6  irq0 GND pulse
v7  ack0 GND pulse
v5  irq1 GND pulse
U18  Net-_U18-Pad1_ int_id_1 dac_bridge_1
U21  int_id_1 plot_v1
U8  Net-_U8-Pad1_ Net-_U10-Pad2_ Net-_U11-Pad2_ Net-_U12-Pad2_ Net-_U13-Pad2_ Net-_U14-Pad2_ Net-_U15-Pad2_ Net-_U16-Pad1_ Net-_U17-Pad1_ Net-_U18-Pad1_ interrupt_controller_ip

.end
