.title KiCad schematic
U14 rst plot_v1
U13 clk plot_v1
v1 Net-_U3-Pad3_ GND DC
v17 clk GND pulse
v4 Net-_U3-Pad6_ GND DC
v3 Net-_U3-Pad5_ GND DC
v2 Net-_U3-Pad4_ GND DC
v18 rst GND pwl
U5 Net-_U5-Pad1_ Net-_U5-Pad2_ Net-_U5-Pad3_ Net-_U5-Pad4_ Net-_U5-Pad5_ Net-_U5-Pad6_ Net-_U5-Pad7_ d6 d5 d4 d3 d2 d1 d0 dac_bridge_7
U4 Net-_U3-Pad9_ Net-_U3-Pad10_ Net-_U3-Pad11_ Net-_U3-Pad12_ Net-_U3-Pad13_ Net-_U3-Pad14_ Net-_U3-Pad15_ Net-_U3-Pad16_ Net-_U1-Pad9_ Net-_U1-Pad10_ Net-_U1-Pad11_ Net-_U1-Pad12_ Net-_U1-Pad13_ Net-_U1-Pad14_ Net-_U1-Pad15_ Net-_U1-Pad16_ Net-_U2-Pad3_ Net-_U2-Pad4_ Net-_U5-Pad1_ Net-_U5-Pad2_ Net-_U5-Pad3_ Net-_U5-Pad4_ Net-_U5-Pad5_ Net-_U5-Pad6_ Net-_U5-Pad7_ hamming_distance
U3 clk rst Net-_U3-Pad3_ Net-_U3-Pad4_ Net-_U3-Pad5_ Net-_U3-Pad6_ Net-_U3-Pad7_ Net-_U3-Pad8_ Net-_U3-Pad9_ Net-_U3-Pad10_ Net-_U3-Pad11_ Net-_U3-Pad12_ Net-_U3-Pad13_ Net-_U3-Pad14_ Net-_U3-Pad15_ Net-_U3-Pad16_ adc_bridge_8
U7 d5 plot_v1
U9 d3 plot_v1
U11 d1 plot_v1
U12 d0 plot_v1
U6 d6 plot_v1
U8 d4 plot_v1
U10 d2 plot_v1
U1 Net-_U1-Pad1_ Net-_U1-Pad2_ Net-_U1-Pad3_ Net-_U1-Pad4_ Net-_U1-Pad5_ Net-_U1-Pad6_ Net-_U1-Pad7_ Net-_U1-Pad8_ Net-_U1-Pad9_ Net-_U1-Pad10_ Net-_U1-Pad11_ Net-_U1-Pad12_ Net-_U1-Pad13_ Net-_U1-Pad14_ Net-_U1-Pad15_ Net-_U1-Pad16_ adc_bridge_8
U2 Net-_U2-Pad1_ Net-_U2-Pad2_ Net-_U2-Pad3_ Net-_U2-Pad4_ adc_bridge_2
v15 Net-_U2-Pad1_ GND DC
v16 Net-_U2-Pad2_ GND DC
v12 Net-_U1-Pad6_ GND DC
v14 Net-_U1-Pad8_ GND DC
v13 Net-_U1-Pad7_ GND DC
v10 Net-_U1-Pad4_ GND DC
v11 Net-_U1-Pad5_ GND DC
v5 Net-_U3-Pad7_ GND DC
v9 Net-_U1-Pad3_ GND DC
v7 Net-_U1-Pad1_ GND DC
v6 Net-_U3-Pad8_ GND DC
v8 Net-_U1-Pad2_ GND DC
.end
